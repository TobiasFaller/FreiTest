.model NMOS NMOS (LEVEL=1 VTO=0.7 KP=200u)
.model PMOS PMOS (LEVEL=1 VTO=-0.7 KP=80u)
.end
