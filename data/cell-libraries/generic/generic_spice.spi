.subckt BUF IN1 OUT VDD VSS
M1 N1  IN1 VDD VDD PMOS W=5u L=0.5u
M2 N1  IN1 VSS VSS NMOS W=2u L=0.5u
M3 OUT N1  VDD VDD PMOS W=5u L=0.5u
M4 OUT N1  VSS VSS NMOS W=2u L=0.5u
.ends BUF

.subckt AND IN1 IN2 OUT VDD VSS
M1 N2  IN1 VDD VDD PMOS W=5u L=0.5u
M2 N2  IN2 VDD VDD PMOS W=5u L=0.5u
M3 N1  IN2 VSS VSS NMOS W=2u L=0.5u
M4 N2  IN1 N1  VSS NMOS W=2u L=0.5u
M5 OUT N2  VDD VDD PMOS W=5u L=0.5u
M6 OUT N2  VSS VSS NMOS W=2u L=0.5u
.ends AND

.subckt OR IN1 IN2 OUT VDD VSS
M1 N1  IN1 VDD VDD PMOS W=5u L=0.5u
M2 N2  IN2 N1  VDD PMOS W=5u L=0.5u
M3 N2  IN1 VSS VSS NMOS W=2u L=0.5u
M4 N2  IN2 VSS VSS NMOS W=2u L=0.5u
M5 OUT N2  VDD VDD PMOS W=5u L=0.5u
M6 OUT N2  VSS VSS NMOS W=2u L=0.5u
.ends OR

.subckt XOR IN1 IN2 OUT VDD VSS
M1  N1  IN1  VDD VDD PMOS W=5u L=0.5u
M2  N1  IN1  VSS VSS NMOS W=2u L=0.5u
M3  N2  IN2  VDD VDD PMOS W=5u L=0.5u
M4  N2  IN2  VSS VSS NMOS W=2u L=0.5u
M5  N3  IN1  VDD VDD PMOS W=5u L=0.5u
M6  N4  N1   VDD VDD PMOS W=5u L=0.5u
M7  OUT N2   N3  VDD PMOS W=5u L=0.5u
M8  OUT IN2  N4  VDD PMOS W=5u L=0.5u
M9  OUT IN1  N5  VSS NMOS W=2u L=0.5u
M10 OUT N1   N6  VSS NMOS W=2u L=0.5u
M11 N5  IN2  VSS VSS NMOS W=2u L=0.5u
M12 N6  N2   VSS VSS NMOS W=2u L=0.5u
.ends XOR

.subckt INV IN1 OUT VDD VSS
M1 OUT IN1 VDD VDD PMOS W=5u L=0.5u
M2 OUT IN1 VSS VSS NMOS W=2u L=0.5u
.ends INV

.subckt NAND IN1 IN2 OUT VDD VSS
M1 OUT IN1 VDD VDD PMOS W=5u L=0.5u
M2 OUT IN2 VDD VDD PMOS W=5u L=0.5u
M3 N1  IN2 VSS VSS NMOS W=2u L=0.5u
M4 OUT IN1 N1  VSS NMOS W=2u L=0.5u
.ends NAND

.subckt NOR IN1 IN2 OUT VDD VSS
M1 N1  IN1 VDD VDD PMOS W=5u L=0.5u
M2 OUT IN2 N1  VDD PMOS W=5u L=0.5u
M3 OUT IN1 VSS VSS NMOS W=2u L=0.5u
M4 OUT IN2 VSS VSS NMOS W=2u L=0.5u
.ends NOR

.subckt XNOR IN1 IN2 OUT VDD VSS
M1  N1  IN1  VDD VDD PMOS W=5u L=0.5u
M2  N1  IN1  VSS VSS NMOS W=2u L=0.5u
M3  N2  IN2  VDD VDD PMOS W=5u L=0.5u
M4  N2  IN2  VSS VSS NMOS W=2u L=0.5u
M5  N3  IN1  VDD VDD PMOS W=5u L=0.5u
M6  N4  N1   VDD VDD PMOS W=5u L=0.5u
M7  OUT IN2  N3  VDD PMOS W=5u L=0.5u
M8  OUT N2   N4  VDD PMOS W=5u L=0.5u
M9  OUT IN1  N5  VSS NMOS W=2u L=0.5u
M10 OUT N1   N6  VSS NMOS W=2u L=0.5u
M11 N5  N2   VSS VSS NMOS W=2u L=0.5u
M12 N6  IN2  VSS VSS NMOS W=2u L=0.5u
.ends XNOR

.subckt MUX IN1 IN2 IN3 OUT VDD VSS
M1  N1  IN3 VDD VDD PMOS W=5u L=0.5u
M2  N1  IN3 VSS VSS NMOS W=2u L=0.5u
M3  N4  IN1 VDD VDD PMOS W=5u L=0.5u
M4  N4  N1  VDD VDD PMOS W=5u L=0.5u
M5  N5  IN2 N4  VDD PMOS W=5u L=0.5u
M6  N5  IN3 N4  VDD PMOS W=5u L=0.5u
M7  N5  IN1 N6  VSS NMOS W=2u L=0.5u
M8  N5  IN2 N7  VSS NMOS W=2u L=0.5u
M9  N6  N1  VSS VSS NMOS W=2u L=0.5u
M10 N7  IN3 VSS VSS NMOS W=2u L=0.5u
M11 OUT N5  VDD VDD PMOS W=5u L=0.5u
M12 OUT N5  VSS VSS NMOS W=2u L=0.5u
.ends MUX

.subckt DL IN1 ENABLE OUT VDD VSS
M1  N1  ENABLE VDD   VDD PMOS W=5u L=0.5u
M2  N1  ENABLE VSS   VSS NMOS W=2u L=0.5u
M3  N2  IN1    VDD   VDD PMOS W=5u L=0.5u
M4  N2  IN1    VSS   VSS NMOS W=2u L=0.5u
M5  N3  N1     N2    VDD PMOS W=5u L=0.5u
M6  N3  ENABLE N2    VSS NMOS W=2u L=0.5u
M7  N3  ENABLE N4    VDD PMOS W=5u L=0.5u
M8  N3  N1     N4    VSS NMOS W=2u L=0.5u
M9  OUT N3     VDD   VDD PMOS W=5u L=0.5u
M10 OUT N3     VSS   VSS NMOS W=2u L=0.5u
M11 N4  OUT    VDD   VDD PMOS W=5u L=0.5u
M12 N4  OUT    VSS   VSS NMOS W=2u L=0.5u
.ends DL

.subckt DLR IN1 ARESET ENABLE OUT VDD VSS
M1  N1  ENABLE VDD   VDD PMOS W=5u L=0.5u
M2  N1  ENABLE VSS   VSS NMOS W=2u L=0.5u
M3  N2  IN1    VDD   VDD PMOS W=5u L=0.5u
M4  N2  IN1    VSS   VSS NMOS W=2u L=0.5u
M5  N3  N1     N2    VDD PMOS W=5u L=0.5u
M6  N3  ENABLE N2    VSS NMOS W=2u L=0.5u
M7  N3  ENABLE N4    VDD PMOS W=5u L=0.5u
M8  N3  N1     N4    VSS NMOS W=2u L=0.5u
M9  N5  N3     VDD   VDD PMOS W=5u L=0.5u
M10 OUT ARESET N5    VDD PMOS W=5u L=0.5u
M11 OUT N3     VSS   VSS NMOS W=2u L=0.5u
M12 OUT ARESET VSS   VSS NMOS W=2u L=0.5u
M13 N4  OUT    VDD   VDD PMOS W=5u L=0.5u
M14 N4  OUT    VSS   VSS NMOS W=2u L=0.5u
.ends DLR

.subckt DFF IN1 CLOCK OUT VDD VSS
M1  N1  CLOCK VDD   VDD PMOS W=5u L=0.5u
M2  N1  CLOCK VSS   VSS NMOS W=2u L=0.5u
M3  N2  IN1   VDD   VDD PMOS W=5u L=0.5u
M4  N2  IN1   VSS   VSS NMOS W=2u L=0.5u
M5  N3  N1    N2    VDD PMOS W=5u L=0.5u
M6  N3  CLOCK N2    VSS NMOS W=2u L=0.5u
M7  N3  CLOCK N4    VDD PMOS W=5u L=0.5u
M8  N3  N1    N4    VSS NMOS W=2u L=0.5u
M9  N5  N3    VDD   VDD PMOS W=5u L=0.5u
M10 N5  N3    VSS   VSS NMOS W=2u L=0.5u
M11 N4  N5    VDD   VDD PMOS W=5u L=0.5u
M12 N4  N5    VSS   VSS NMOS W=2u L=0.5u
M13 N6  N5    VDD   VDD PMOS W=5u L=0.5u
M14 N6  N5    VSS   VSS NMOS W=2u L=0.5u
M15 N7  CLOCK N6    VDD PMOS W=5u L=0.5u
M16 N7  N1    N6    VSS NMOS W=2u L=0.5u
M17 N7  N1    N8    VDD PMOS W=5u L=0.5u
M18 N7  CLOCK N8    VSS NMOS W=2u L=0.5u
M19 OUT N7    VDD   VDD PMOS W=5u L=0.5u
M20 OUT N7    VSS   VSS NMOS W=2u L=0.5u
M21 N8  OUT   VDD   VDD PMOS W=5u L=0.5u
M22 N8  OUT   VSS   VSS NMOS W=2u L=0.5u
.ends DFF

.subckt DFFR IN1 ARESET CLOCK OUT VDD VSS
M1  N1  CLOCK  VDD   VDD PMOS W=5u L=0.5u
M2  N1  CLOCK  VSS   VSS NMOS W=2u L=0.5u
M3  N2  IN1    VDD   VDD PMOS W=5u L=0.5u
M4  N2  IN1    VSS   VSS NMOS W=2u L=0.5u
M5  N3  N1     N2    VDD PMOS W=5u L=0.5u
M6  N3  CLOCK  N2    VSS NMOS W=2u L=0.5u
M7  N3  CLOCK  N4    VDD PMOS W=5u L=0.5u
M8  N3  N1     N4    VSS NMOS W=2u L=0.5u
M9  N5  N3     VDD   VDD PMOS W=5u L=0.5u
M10 N6  ARESET N5    VDD PMOS W=5u L=0.5u
M11 N6  N3     VSS   VSS NMOS W=2u L=0.5u
M12 N6  ARESET VSS   VSS NMOS W=2u L=0.5u
M13 N4  N6     VDD   VDD PMOS W=5u L=0.5u
M14 N4  N6     VSS   VSS NMOS W=2u L=0.5u
M15 N7  N6     VDD   VDD PMOS W=5u L=0.5u
M16 N7  N6     VSS   VSS NMOS W=2u L=0.5u
M17 N8  CLOCK  N7    VDD PMOS W=5u L=0.5u
M18 N8  N1     N7    VSS NMOS W=2u L=0.5u
M19 N8  N1     N10   VDD PMOS W=5u L=0.5u
M20 N8  CLOCK  N10   VSS NMOS W=2u L=0.5u
M21 N9  N8     VDD   VDD PMOS W=5u L=0.5u
M22 OUT ARESET N9    VDD PMOS W=5u L=0.5u
M23 OUT N8     VSS   VSS NMOS W=2u L=0.5u
M24 OUT ARESET VSS   VSS NMOS W=2u L=0.5u
M25 N10 OUT    VDD   VDD PMOS W=5u L=0.5u
M26 N10 OUT    VSS   VSS NMOS W=2u L=0.5u
.ends DFFR

.end
